.subckt recursive p n
xself p n recursive
.ends recursive
.end
